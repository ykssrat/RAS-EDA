ADE simulation setup
Run mode: Monte Carlo Sampling
Tests:
  SRAM_1KB:TB_mac_Sense:1: SRAM_1KB/TB_mac_Sense/schematic, simulator spectre
Corners (nominal off):
  model folders: /home/work/Desktop/BY/iPDK_CRN28HPC+_v1.0_2p2a_20160226_all/CRN28HPCp/models/spectre
  C0: toplevel_2d5.scs[top_globalmc_localmc]
Monte Carlo Sampling options: mcmethod=all, mcnumpoints=100
